# Ansys Electronics Desktop project, version 2023.2
materials:
  vacuum: permittivity=1
  FR4_epoxy: permittivity=4.4 dielectric_loss_tangent=0.02
  copper: permeability=0.999991 conductivity=58000000

design HFSSDesign1 (HFSS, HFSS Terminal Network, model units mm)
geometry:
  Box1 [FR4_epoxy] = box(corner=(0mm, 0mm, 0mm), size=(26.5mm, 31mm, 0.8mm))
  GRound = rectangle(corner=(0mm, 0mm, 0mm), x_size=26.5mm, y_size=31mm)
  Box2 [copper] = box(corner=(7mm, 0mm, 0.8mm), size=(1.3175mm, 30mm, 0.135mm))
  Box3 = box(corner=(8.3175mm, 30mm, 0.8mm), size=(17.2mm, -1mm, 0.135mm))
  Box4 = box(corner=(7mm, 30mm, 0.8mm), size=(-6mm, -1mm, 0.135mm))
  Box5 = box(corner=(1mm, 29mm, 0.8mm), size=(1mm, -18mm, 0.135mm))
  Box2.unite(Box3, Box4, Box5)
  Source [copper] = object_from(Box2.edge(4 of 12))
  Source.sweep_along_vector((0mm, 0mm, -0.935mm))
  Air [vacuum] = box(corner=(0mm, 0mm, 0mm), size=(26.5mm, 31mm, 15mm))
boundaries and excitations:
  PerfE_Gnd: Perfect E Objects=GRound
  PerfE_patch: Perfect E Objects=Box2
  Radiation: Radiation Faces=Air.face(+z, -y, -x, +y, +x)
  2: Wave Port Objects=Source WavePortType=Modal NumModes=1 Modes{Mode1{CharImp=Zpi}}
  reference conductors: GRound
setups:
  Setup1: HfssDriven Frequency=868MHz MaxDeltaS=0.02 MaximumPasses=10 MinimumPasses=1 MinimumConvergedPasses=1 PercentRefinement=30 BasisOrder=1 PortAccuracy=2 DrivenSolverType="Direct Solver"
    sweep Sweep: 434MHz to 1302MHz, 401 points; Type=Discrete SaveFields
source amplitudes:
  2:1: 1V 0deg
radiation setups:
  Infinite Sphere1: Infinite Sphere Theta=0deg..180deg step 10deg Phi=-180deg..180deg step 10deg
reports:
  Terminal S Parameter Plot 1: dB(St(2,2)) vs Freq on Setup1 : Sweep
  Active S Parameter Plot 1: dB(ActiveS(2:1)) vs Freq on Setup1 : Sweep
